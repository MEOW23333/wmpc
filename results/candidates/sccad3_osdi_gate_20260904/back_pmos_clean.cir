* SCCAD 3nm PMOS gate
.include results/candidates/sccad3_osdi_gate_20260904/models/back_osdi_clean.sp
VSRC s 0 0.7
VG g 0 0.7
NP0 0 g s s PMOS_LVT
.control
pre_osdi /home/ZhangLexin/PALS/wmpc-gt2n-compat/results/gt2n_ngspice_compat_20260903/toolchain_check/openvaf/bsimcmg_v111.osdi
op
dc VG 0.7 0 -0.1
print v(g) i(vsrc)
quit
.endc
.end
