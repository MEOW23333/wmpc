* FreePDK3 no-PRWG PMOS gate
.include results/candidates/freepdk3_v108_20260904/models/no_prwg_bsimcmg.mod
VSRC s 0 0.7
VG g 0 0.7
NP0 0 g s s pfet
.control
pre_osdi /home/ZhangLexin/PALS/wmpc-gt2n-compat/results/gt2n_ngspice_compat_20260903/toolchain_check/bsim_versions/bsimcmg_v108.osdi
op
dc VG 0.7 0 -0.1
print v(g) i(vsrc)
quit
.endc
.end
