* FreePDK3 no-PRWG slow inverter gate
.include results/candidates/freepdk3_v108_20260904/models/no_prwg_bsimcmg.mod
VDD vdd 0 0.7
VIN in 0 PULSE(0 0.7 10p 2p 2p 80p 200p)
NP0 out in vdd vdd pfet
NN0 out in 0 0 nfet
CLOAD out 0 1f
.control
pre_osdi /home/ZhangLexin/PALS/wmpc-gt2n-compat/results/gt2n_ngspice_compat_20260903/toolchain_check/bsim_versions/bsimcmg_v108.osdi
op
dc VIN 0 0.7 0.1
print v(in) v(out)
tran 1p 400p
meas tran vout_input_low_1 FIND v(out) AT=5p
meas tran vout_input_high_1 FIND v(out) AT=50p
meas tran vout_input_low_2 FIND v(out) AT=150p
meas tran vout_input_high_2 FIND v(out) AT=250p
quit
.endc
.end
