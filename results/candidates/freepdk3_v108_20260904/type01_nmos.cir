* FreePDK3 no-PRWG NMOS gate
.include results/candidates/freepdk3_v108_20260904/models/type01_no_prwg_bsimcmg.mod
VD d 0 0.7
VG g 0 0
NN0 d g 0 0 nfet
.control
pre_osdi /home/ZhangLexin/PALS/wmpc-gt2n-compat/results/gt2n_ngspice_compat_20260903/toolchain_check/bsim_versions/bsimcmg_v108.osdi
op
dc VG 0 0.7 0.1
print v(g) i(vd)
quit
.endc
.end
