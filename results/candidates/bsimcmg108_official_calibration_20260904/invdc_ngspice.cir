* BSIM-CMG 108 official inverter DC calibration
.include results/candidates/bsimcmg108_official_calibration_20260904/models/modelcard.nmos
.include results/candidates/bsimcmg108_official_calibration_20260904/models/modelcard.pmos
VDD supply 0 1.0
VIN vi 0 0
NP1 vo vi supply 0 pmos1 TFIN=15n L=30n NFIN=10 NRS=1 NRD=1
NN1 vo vi 0 0 nmos1 TFIN=15n L=30n NFIN=10 NRS=1 NRD=1
.control
pre_osdi /home/ZhangLexin/PALS/wmpc-gt2n-compat/results/gt2n_ngspice_compat_20260903/toolchain_check/bsim_versions/bsimcmg_v108.osdi
op
dc VIN 0 1 0.01
print v(vi) v(vo)
quit
.endc
.end
